# Ansys Electronics Desktop project, version 2021.2
materials:
  vacuum: permittivity=1
  pec: conductivity=1e+30
  Teflon (tm): permittivity=2.1 dielectric_loss_tangent=0.001
  sapphire: permittivity=10
  silicon: permittivity=11.9

design HFSSDesign1 (HFSS, DrivenModal, model units mm)
geometry:
  WR229CMR229Flange_Jake_Model = imported_body(S:\fitzlab\cad\Waveguide\CoupledWaveguide.STEP)
  WR229CMR229Flange_Jake_Model_1 [pec] = imported_body(S:\fitzlab\cad\Waveguide\CoupledWaveguide.STEP)
  DrivenModalCap, DrivenModalCap_1 [Teflon (tm)] = imported_body(S:\fitzlab\cad\Waveguide\CoupledWaveguide.STEP)
  pin, pin_1 [pec] = imported_body(S:\fitzlab\cad\Waveguide\CoupledWaveguide.STEP)
  Box1 = box(corner=(0mm, 65.6336mm, -49.022mm), size=(36.5739934mm, -65.6336mm, 110.744mm))
  Box2 = box(corner=(-6.35mm, 71.9836mm, -5.08mm), size=(49.2739934mm, -78.3336mm, 22.86mm))
  Box2.subtract(Box1)
  Box2_1 = Box2.copy()
  WR229CMR229Flange_Jake_Model.subtract(Box2_1)
  WR229CMR229Flange_Jake_Model_1.subtract(Box2)
  Region [vacuum] = region(percentage_offset=0 on all sides)
  Circle1 = circle(normal=X, centre=(36.5739934mm, 32.8168mm, 36.3474mm), radius=2.5mm)
  Circle2 = circle(normal=X, centre=(36.5739934mm, 32.8168mm, -23.6474mm), radius=2.5mm)
  [WR229CMR229Flange_Jake_Model, WR229CMR229Flange_Jake_Model_1, DrivenModalCap, DrivenModalCap_1, pin, pin_1, Circle1, Circle2].move(-20mm, 0mm, 0mm)
  [WR229CMR229Flange_Jake_Model, WR229CMR229Flange_Jake_Model_1, DrivenModalCap, DrivenModalCap_1, pin, pin_1, Circle1, Circle2].move(0mm, -30mm, 0mm)
  WR229CMR229Flange_Jake_Model_1.unite(WR229CMR229Flange_Jake_Model)
  Rectangle2 [sapphire] = rectangle(corner=(-13mm, (2.8168-11) mm, 6mm), x_size=25.5mm, y_size=5.5mm)
  Rectangle2.thicken(0.5mm)
  Rectangle3 [sapphire] = rectangle(corner=(-13mm, (2.8168+5.5) mm, 6mm), x_size=25.5mm, y_size=5.5mm)
  Rectangle3.thicken(0.5mm)
  Rectangle4 [sapphire] = rectangle(corner=(-13mm, (2.8168-5.5) mm, 6mm), x_size=25.5mm, y_size=5.5mm)
  Rectangle4.thicken(0.5mm)
  Rectangle5 [sapphire] = rectangle(corner=(-13mm, 2.8168mm, 6mm), x_size=25.5mm, y_size=5.5mm)
  Rectangle5.thicken(0.5mm)
  group CoupledWaveguide = WR229CMR229Flange_Jake_Model_1, DrivenModalCap, DrivenModalCap_1, pin, pin_1
boundaries and excitations:
  port1: Wave Port Faces=Circle1.face(#1574) NumModes=5 Modes{Mode1{CharImp=Zpi} Mode2{CharImp=Zpi} Mode3{CharImp=Zpi} Mode4{CharImp=Zpi} Mode5{CharImp=Zpi}}
  port2: Wave Port Faces=Circle2.face(#1586) NumModes=5 Modes{Mode1{CharImp=Zpi} Mode2{CharImp=Zpi} Mode3{CharImp=Zpi} Mode4{CharImp=Zpi} Mode5{CharImp=Zpi}}
setups:
  Setup1: HfssDriven Frequency=4GHz MaxDeltaS=0.02 MaximumPasses=6 MinimumPasses=1 MinimumConvergedPasses=1 PercentRefinement=30 BasisOrder=1 PortAccuracy=2
    sweep Sweep: 2GHz to 6GHz, 401 points; Type=Interpolating SaveFields InterpTolerance=0.5 InterpMaxSolns=250 InterpUsePortImped=false PassivityErrorTolerance=0.0001
source amplitudes:
  port1:1: 1W 0deg
  port1:2..port1:5, port2:1..port2:5: 0W 0deg
reports:
  S Parameter Plot 2: dB(S(port2:1,port1:1)) vs Freq on Setup1 : Sweep
  S Parameter Plot 3: dB(S(port2:2,port1:1)) vs Freq on Setup1 : Sweep
  S Parameter Plot 4: dB(S(port1:1,port2:1)) vs Freq on Setup1 : Sweep
  S Parameter Plot 5: dB(S(port2:2,port1:2)) vs Freq on Setup1 : Sweep
  S Parameter Plot 6: dB(S(port2:3,port1:3)) vs Freq on Setup1 : Sweep
  S Parameter Plot 7: dB(S(port2:4,port1:4)) vs Freq on Setup1 : Sweep
  S Parameter Plot 8: dB(S(port2:5,port1:5)) vs Freq on Setup1 : Sweep
  S Parameter Plot 9: dB(S(port1:1,port1:1)) vs Freq on Setup1 : Sweep
